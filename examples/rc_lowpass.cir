* Passive RC low-pass, reference for ngspice comparison
Vin in 0 AC 1 SIN(0 1 1000)
R1 in out 10k
C1 out 0 10n
.control
op
ac dec 100 10 100k
tran 1u 10m
.endc
.end
